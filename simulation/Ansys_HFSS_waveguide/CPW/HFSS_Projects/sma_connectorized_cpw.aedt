# Ansys Electronics Desktop project, version 2024.2
materials:
  vacuum: permittivity=1
  bronze: conductivity=10000000
  Teflon (tm): permittivity=2.1 dielectric_loss_tangent=0.001
  copper: permeability=0.999991 conductivity=58000000
  tin: conductivity=8670000
  Rogers TMM 3 (tm): permittivity=3.27 dielectric_loss_tangent=0.002
  air: permittivity=1.0006 permeability=1.0000004

design sma_connectorized_cpw (HFSS, HFSS Hybrid Terminal Network, model units mm)
geometry:
  sma_cpw_Unnamed_2 [bronze] = imported_body(C:\00_Asenjo\00_Project\Ketupa\simulation\Ansys_HFSS_waveguide\CPW\dxf\sma_cpw.sab)
  sma_cpw_Unnamed_3 [Teflon (tm)] = imported_body(C:\00_Asenjo\00_Project\Ketupa\simulation\Ansys_HFSS_waveguide\CPW\dxf\sma_cpw.sab)
  sma_cpw_Unnamed_4 [copper] = imported_body(C:\00_Asenjo\00_Project\Ketupa\simulation\Ansys_HFSS_waveguide\CPW\dxf\sma_cpw.sab)
  sma_cpw_Unnamed_5 [bronze] = imported_body(C:\00_Asenjo\00_Project\Ketupa\simulation\Ansys_HFSS_waveguide\CPW\dxf\sma_cpw.sab)
  sma_cpw_Unnamed_7 [Rogers TMM 3 (tm)] = imported_body(C:\00_Asenjo\00_Project\Ketupa\simulation\Ansys_HFSS_waveguide\CPW\dxf\sma_cpw.sab)
  sma_cpw_Unnamed_8 = imported_body(C:\00_Asenjo\00_Project\Ketupa\simulation\Ansys_HFSS_waveguide\CPW\dxf\sma_cpw.sab)
  sma_cpw_Unnamed_9 [copper] = imported_body(C:\00_Asenjo\00_Project\Ketupa\simulation\Ansys_HFSS_waveguide\CPW\dxf\sma_cpw.sab)
  micro_line [copper, solve inside] = box(corner=(0mm, 16.4mm, 1.524mm), size=(60mm, -2.8mm, 0.05mm))
  Gnd1 [copper, solve inside] = box(corner=(0mm, 17.9mm, 1.524mm), size=(60mm, 12.1mm, 0.05mm))
  Gnd2 [copper, solve inside] = box(corner=(0mm, 12mm, 1.524mm), size=(60mm, -12mm, 0.05mm))
  micro_line.unite(sma_cpw_Unnamed_8)
  port1 = circle(normal=X, centre=(-8mm, 15mm, 2.159mm), radius=2.6594137mm)
  port2 = rectangle(corner=(60mm, 0mm, 0mm), y_size=30mm, z_size=5mm)
  Air_Region [air] = region(percentage_offset=0 on all sides)
  group sma_cpw = sma_cpw_Unnamed_2..sma_cpw_Unnamed_5, sma_cpw_Unnamed_7, sma_cpw_Unnamed_9
boundaries and excitations:
  sma_cpw_Unnamed_4_T1: Terminal port=1 Faces=sma_cpw_Unnamed_4.face(at (-8, 15, 2.159)) TerminalResistance=50ohm
  micro_line_T1: Terminal port=2 Faces=micro_line.face(+x) TerminalResistance=50ohm
  1: Lumped Port Faces=port1.face LumpedPortType=Terminal Impedance=50ohm
  2: Lumped Port Faces=port2.face LumpedPortType=Terminal Impedance=50ohm
  reference conductors: Gnd1, Gnd2
setups:
  Setup1: HfssDriven Frequency=2.4GHz MaxDeltaS=0.02 MaximumPasses=6 MinimumPasses=1 MinimumConvergedPasses=1 PercentRefinement=30 BasisOrder=1 PortAccuracy=2 DrivenSolverType="Direct Solver"
    sweep Sweep: 0Hz to 1Hz, 1 points; 1Hz to 100MHz, log, 20 per decade; 100MHz to 1GHz step 10MHz; 1GHz to 8GHz step 10MHz; Type=Interpolating SaveFields SaveRadFields InterpTolerance=0.5 InterpMaxSolns=250 MinSolvedFreq=0.01GHz PassivityErrorTolerance=0.0001
source amplitudes:
  1:1: 1V 0deg
  2:1: 0V 0deg
reports:
  Terminal S Parameter Plot 1: dB(St(sma_cpw_Unnamed_4_T1,sma_cpw_Unnamed_4_T1)), dB(St(micro_line_T1,sma_cpw_Unnamed_4_T1)) vs Freq on Setup1 : Sweep
